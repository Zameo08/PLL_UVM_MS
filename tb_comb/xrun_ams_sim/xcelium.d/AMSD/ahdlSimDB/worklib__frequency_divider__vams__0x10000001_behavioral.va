`include "constants.vams"

nature Power
  access = Pwr;
  units = "W";
  abstol = 1e-09;
endnature

nature Position
  access = Pos;
  units = "m";
  abstol = 1e-06;
  ddt_nature = Velocity;
endnature

nature Angular_Acceleration
  access = Alpha;
  units = "rads/s^2";
  abstol = 1e-06;
  idt_nature = Angular_Velocity;
endnature

nature Temperature
  access = Temp;
  units = "C";
  abstol = 0.0001;
endnature

nature Velocity
  access = Vel;
  units = "m/s";
  abstol = 1e-06;
  idt_nature = Position;
  ddt_nature = Acceleration;
endnature

nature Acceleration
  access = Acc;
  units = "m/s^2";
  abstol = 1e-06;
  idt_nature = Velocity;
  ddt_nature = Impulse;
endnature

nature Flux
  access = Phi;
  units = "Wb";
  abstol = 1e-09;
  ddt_nature = Voltage;
endnature

nature Charge
  access = Q;
  units = "coul";
  abstol = 1e-14;
  ddt_nature = Current;
endnature

nature Impulse
  access = Imp;
  units = "m/s^3";
  abstol = 1e-06;
  idt_nature = Acceleration;
endnature

nature Voltage
  access = V;
  units = "V";
  abstol = 1e-06;
  idt_nature = Flux;
endnature

nature Angular_Force
  access = Tau;
  units = "N*m";
  abstol = 1e-06;
endnature

nature Magneto_Motive_Force
  access = MMF;
  units = "A*turn";
  abstol = 1e-12;
endnature

nature Force
  access = F;
  units = "N";
  abstol = 1e-06;
endnature

nature Angular_Velocity
  access = Omega;
  units = "rads/s";
  abstol = 1e-06;
  idt_nature = Angle;
  ddt_nature = Angular_Acceleration;
endnature

nature Current
  access = I;
  units = "A";
  abstol = 1e-12;
  idt_nature = Charge;
endnature

nature Angle
  access = Theta;
  units = "rads";
  abstol = 1e-06;
  ddt_nature = Angular_Velocity;
endnature

discipline kinematic_v
  domain continuous;
  potential Velocity;
  flow Force;
enddiscipline

discipline rotational_omega
  domain continuous;
  potential Angular_Velocity;
  flow Angular_Force;
enddiscipline

discipline electrical
  domain continuous;
  potential Voltage;
  flow Current;
enddiscipline

discipline rotational
  domain continuous;
  potential Angle;
  flow Angular_Force;
enddiscipline

discipline kinematic
  domain continuous;
  potential Position;
  flow Force;
enddiscipline

discipline voltage
  domain continuous;
  potential Voltage;
enddiscipline

discipline magnetic
  domain continuous;
  potential Magneto_Motive_Force;
  flow Flux;
enddiscipline

discipline thermal
  domain continuous;
  potential Temperature;
  flow Power;
enddiscipline

discipline current
  domain continuous;
  potential Current;
enddiscipline

(* vams_to_va="/home/huyen_k66/Documents/PLL_UVM_MS/src_vams/frequency_divider.vams" *)

module worklib__frequency_divider__vams__0x10000001_behavioral(clk, vout);
 //L=8
parameter real vtrans = 0.5;
//L=9
parameter real \delay  = 0;
//L=10
parameter real ttime = 1e-12;
//L=11
parameter real clk_threshold = 0.5;
//L=12
parameter real N = 64;
//L=17
electrical clk;
//L=17
electrical vout;
//L=19
real counter;
//L=19
real v_out;
analog
   begin
//L=23
    @ ((initial_step("all")))      begin
//L=24
      (v_out = 0);
//L=24
      (counter = 0);
    end
//L=26
    @ ((cross((V(clk) -clk_threshold), 1)))      begin
//L=28
      if ((counter < ((N/2)-1)))        begin
//L=29
        (counter = (counter+1));
//L=29
        (v_out = 0);
      end
 else //L=30
      if ((counter < (N-1)))        begin
//L=31
        (counter = (counter+1));
//L=31
        (v_out = 1);
      end
 else //L=32
      if ((counter == (N-1)))        begin
//L=33
        (counter = 0);
//L=33
        (v_out = 0);
      end
    end
//L=36
    V(vout)  <+ (transition(v_out, \delay , ttime));
  end

endmodule
