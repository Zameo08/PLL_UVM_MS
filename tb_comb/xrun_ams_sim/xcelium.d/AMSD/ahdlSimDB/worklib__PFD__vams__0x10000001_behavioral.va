`include "constants.vams"

nature Power
  access = Pwr;
  units = "W";
  abstol = 1e-09;
endnature

nature Position
  access = Pos;
  units = "m";
  abstol = 1e-06;
  ddt_nature = Velocity;
endnature

nature Angular_Acceleration
  access = Alpha;
  units = "rads/s^2";
  abstol = 1e-06;
  idt_nature = Angular_Velocity;
endnature

nature Temperature
  access = Temp;
  units = "C";
  abstol = 0.0001;
endnature

nature Velocity
  access = Vel;
  units = "m/s";
  abstol = 1e-06;
  idt_nature = Position;
  ddt_nature = Acceleration;
endnature

nature Acceleration
  access = Acc;
  units = "m/s^2";
  abstol = 1e-06;
  idt_nature = Velocity;
  ddt_nature = Impulse;
endnature

nature Flux
  access = Phi;
  units = "Wb";
  abstol = 1e-09;
  ddt_nature = Voltage;
endnature

nature Charge
  access = Q;
  units = "coul";
  abstol = 1e-14;
  ddt_nature = Current;
endnature

nature Impulse
  access = Imp;
  units = "m/s^3";
  abstol = 1e-06;
  idt_nature = Acceleration;
endnature

nature Voltage
  access = V;
  units = "V";
  abstol = 1e-06;
  idt_nature = Flux;
endnature

nature Angular_Force
  access = Tau;
  units = "N*m";
  abstol = 1e-06;
endnature

nature Magneto_Motive_Force
  access = MMF;
  units = "A*turn";
  abstol = 1e-12;
endnature

nature Force
  access = F;
  units = "N";
  abstol = 1e-06;
endnature

nature Angular_Velocity
  access = Omega;
  units = "rads/s";
  abstol = 1e-06;
  idt_nature = Angle;
  ddt_nature = Angular_Acceleration;
endnature

nature Current
  access = I;
  units = "A";
  abstol = 1e-12;
  idt_nature = Charge;
endnature

nature Angle
  access = Theta;
  units = "rads";
  abstol = 1e-06;
  ddt_nature = Angular_Velocity;
endnature

discipline kinematic_v
  domain continuous;
  potential Velocity;
  flow Force;
enddiscipline

discipline rotational_omega
  domain continuous;
  potential Angular_Velocity;
  flow Angular_Force;
enddiscipline

discipline electrical
  domain continuous;
  potential Voltage;
  flow Current;
enddiscipline

discipline rotational
  domain continuous;
  potential Angle;
  flow Angular_Force;
enddiscipline

discipline kinematic
  domain continuous;
  potential Position;
  flow Force;
enddiscipline

discipline voltage
  domain continuous;
  potential Voltage;
enddiscipline

discipline magnetic
  domain continuous;
  potential Magneto_Motive_Force;
  flow Flux;
enddiscipline

discipline thermal
  domain continuous;
  potential Temperature;
  flow Power;
enddiscipline

discipline current
  domain continuous;
  potential Current;
enddiscipline

(* vams_to_va="/home/huyen_k66/Documents/PLL_UVM_MS/src_vams/PFD.vams" *)

module worklib__PFD__vams__0x10000001_behavioral(up, dn, upb, dnb, fref, fdiv);
 //L=9
parameter real \delay  = 0;
//L=10
parameter real ttime = 1e-12;
//L=11
parameter real clk_threshold = 0.5;
//L=17
electrical fref;
//L=17
electrical fdiv;
//L=17
electrical up;
//L=17
electrical upb;
//L=17
electrical dn;
//L=17
electrical dnb;
//L=19
real upr;
//L=19
real upbr;
//L=19
real dnr;
//L=19
real dnbr;
analog
   begin
//L=23
    @ ((cross((V(fref) -clk_threshold), 1)))      begin
//L=25
      (upr = 1);
//L=25
      (upbr = 0);
    end
//L=28
    @ ((cross((V(fdiv) -clk_threshold), 1)))      begin
//L=30
      (dnr = 1);
//L=30
      (dnbr = 0);
    end
//L=34
    if ((dnr == upr))      begin
//L=35
      (upr = 0);
//L=35
      (dnr = 0);
//L=35
      (upbr = 1);
//L=35
      (dnbr = 1);
    end
//L=38
    V(up)  <+ (transition(upr, \delay , ttime));
//L=39
    V(dn)  <+ (transition(dnr, \delay , ttime));
//L=40
    V(upb)  <+ (transition(upbr, \delay , ttime));
//L=41
    V(dnb)  <+ (transition(dnbr, \delay , ttime));
  end

endmodule
