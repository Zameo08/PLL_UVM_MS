//*** amscb_ie_crules.vams ***
//* connect rules file for AMSCB IE card
//* This file is automatically generated.

//* (c) Copyright 2007-2010 Cadence Design Systems, Inc.
//* All rights reserved.

`include "disciplines.vams"

// using connectrule: uCR
discipline ddiscrete_1_8
  domain discrete;
enddiscipline

`define accuracy "moderate"
`define vsup 1.8
`define rout 200
`define tr 200p
`define vsupmin 0.5
`define vss 0
`define vlo `vss
`define vhi `vsup+`vss
`define vthi `vlo+(`vhi-(`vlo))*2.0/3.0
`define vtlo `vlo+(`vhi-(`vlo))/3.0
`define vx `accuracy=="conservative"?(`vhi+(`vlo))/2.0:`vlo
`define vz `accuracy=="conservative"?(`vhi+(`vlo))/2.0:`vlo
`define vtol (`vthi-(`vtlo))/(`accuracy=="conservative"?10.0:4.0)
`define tf `tr
`define txdel (`tr)*4.0
`define tdeltran 0
`define tdeltran_rise `tdeltran
`define tdeltran_fall `tdeltran_rise
`define ttoltran (`tr)/10.0
`define ttolcross (`tr)/4.0
`define rlo `rout
`define rhi `rout
`define rx `accuracy=="conservative"?(`rlo+(`rhi))/10:(`rlo+(`rhi))/2
`define rz 10M
`define vdelta (`vsup)/64.0
`define vtoldelta (`vdelta)/4.0
`define ttoldelta (`tr)/20.0
`define vpso 0.2
`define rsupply ((`rhi>`rlo)?`rlo:`rhi)/2.5<4?((`rhi>`rlo)?`rlo:`rhi)/2.5:4
`define rpull ((`rhi>`rlo)?`rhi:`rlo)*2.5>1.5e3?((`rhi>`rlo)?`rhi:`rlo)*2.5:1.5e3
`define rlarge (`rpull)*2.5>9.0e3?(`rpull)*2.5:9.0e3
`define rweak (`rlarge)*2.5>5.5e4?(`rlarge)*2.5:5.5e4
`define rmedium (`rweak)*2.5>3.2e5?(`rweak)*2.5:3.2e5
`define rsmall (`rmedium)*2.5>1.9e6?(`rmedium)*2.5:1.9e6
`define vtrhi (`vthi)/(`vsup)
`define vtrlo (`vtlo)/(`vsup)
`define vrtol (`vtol)/(`vsup)
`define nox `accuracy=="liberal"?1:0
`define ignore_xz `accuracy=="liberal"?1:0
`define analog_load `accuracy=="conservative"?1:0
`define ramp_type `accuracy=="conservative"?1:0
`define debug 0
`define vinlimit `vss+(`vsup)*4.0/3.0
`define vddlimit `vss+(`vsup)*4.0/3.0
`define vsup_low_output_x 0
`define enable_ilimit 0
`define ilimit 500u
`define bidir_trangate 0
`define currentmode 0
`define clamp 0
`define rin 200
`define idelta 10u
`define itoldelta (`idelta)/4.0
`define ix 0
`define vbias `vss+(`vsup)/2.0
`define dvclamp (`vsup)/20.0
`define enable_highz 0
`define duration 5n
`define Ts 1n
`define Ra 100
`define MaxIter 4
`define Vtol 1e-6
`define Itol 1e-10
`define Rrel 1e-4
`define Roff 1e12
`define Vx 0
`define Rx `Roff

connectrules ddiscrete_1_8_cr;
connect E2R_LPS  #(  .vdelta(`vdelta), .vtol(`vtoldelta), .ttol(`ttoldelta), .currentmode(`currentmode), .debug(`debug), .vinlimit(`vinlimit)  )ddiscrete_1_8, electrical;
connect EEnet_2_E  #(  .Ts(`Ts), .Ra(`Ra), .MaxIter(`MaxIter), .Vtol(`Vtol), .Itol(`Itol), .Rrel(`Rrel), .Roff(`Roff), .Vx(`Vx), .Rx(`Rx) )ddiscrete_1_8, electrical;
connect ER_Bidir_LPS  #(  .vdelta(`vdelta), .vtol(`vtoldelta), .ttol(`ttoldelta), .tr(`ttoldelta), .tf(`ttoldelta), .tdelay(`tdeltran), .rout(`rout), .rz(`rz), .vpso(`vpso), .currentmode(`currentmode), .debug(`debug), .vinlimit(`vinlimit)  )ddiscrete_1_8, electrical;
connect E_2_EEnet  #(  .Ts(`Ts), .Ra(`Ra), .MaxIter(`MaxIter), .Vtol(`Vtol), .Itol(`Itol), .Rrel(`Rrel), .Roff(`Roff), .Vx(`Vx), .Rx(`Rx) )ddiscrete_1_8, electrical;
connect E_EEnet_Bidir  #(  .Ts(`Ts), .Ra(`Ra), .MaxIter(`MaxIter), .Vtol(`Vtol), .Itol(`Itol), .Rrel(`Rrel), .Roff(`Roff), .Vx(`Vx), .Rx(`Rx) )ddiscrete_1_8, electrical;
connect L2R  #(  .vsup(`vsup), .vlo(`vlo), .vhi(`vhi)  )ddiscrete_1_8, ddiscrete_1_8;
connect L2R_LPS  #(  .vsup(`vsup), .vlo(`vlo), .vhi(`vhi)  )ddiscrete_1_8, ddiscrete_1_8;
connect R2E_2_LPS  #(  .vsup(`vsup), .vdelta(`vdelta), .vlo(`vlo), .vx(`vx), .tr(`ttoldelta), .tf(`ttoldelta), .tdelay(`tdeltran), .rout(`rout), .rx(`rx), .rz(`rz), .vpso(`vpso), .currentmode(`currentmode), .debug(`debug), .vinlimit(`vinlimit)  )ddiscrete_1_8, electrical;
connect R2L  #(  .vsup(`vsup), .vlo(`vlo), .vhi(`vhi), .vtlo(`vtlo), .vthi(`vthi)  )ddiscrete_1_8, ddiscrete_1_8;
connect R2L_LPS  #(  .vsup(`vsup), .vlo(`vlo), .vhi(`vhi), .vtlo(`vtlo), .vthi(`vthi), .vtrhi(`vtrhi), .vtrlo(`vtrlo) )ddiscrete_1_8, ddiscrete_1_8;
connect RL_Bidir_LPS  #(  .vsup(`vsup), .vlo(`vlo), .vhi(`vhi), .vtlo(`vtlo), .vthi(`vthi), .vtrhi(`vtrhi), .vtrlo(`vtrlo) )ddiscrete_1_8, ddiscrete_1_8;
connect RL_bidir  #(  .vsup(`vsup), .vlo(`vlo), .vhi(`vhi), .vtlo(`vtlo), .vthi(`vthi)  )ddiscrete_1_8, ddiscrete_1_8;
connect uBidir  #(  .accuracy(`accuracy), .vsup(`vsup), .vhi(`vhi), .vlo(`vlo), .vthi(`vthi), .vtlo(`vtlo), .tr(`tr), .tf(`tf), .vtol(`vtol), .txdel(`txdel), .nox(`nox), .ttol_c(`ttolcross), .vsup_min(`vsupmin), .enable_highz(`enable_highz), .duration(`duration), .ignore_xz(`ignore_xz), .vx(`vx), .vz(`vz), .bidir_trangate(`bidir_trangate), .ttol_t(`ttoltran), .tdeltran_rise(`tdeltran_rise), .tdeltran_fall(`tdeltran_fall), .ramp_type(`ramp_type), .rhi(`rhi), .rlo(`rlo), .rx(`rx), .rz(`rz), .analog_load(1), .r_SUPPLY(`rsupply), .r_PULL(`rpull), .r_LARGE(`rlarge), .r_WEAK(`rweak), .r_MEDIUM(`rmedium), .r_SMALL(`rsmall), .debug(`debug), .vinlimit(`vinlimit), .vddlimit(`vddlimit), .vpso(`vpso), .vsup_low_output_x(`vsup_low_output_x), .enable_ilimit(`enable_ilimit), .ilimit(`ilimit)  )ddiscrete_1_8, electrical;
connect uBidir_LPS  #(  .accuracy(`accuracy), .vsup(`vsup), .vhi(`vhi), .vlo(`vlo), .vthi(`vthi), .vtlo(`vtlo), .tr(`tr), .tf(`tf), .vtol(`vtol), .txdel(`txdel), .nox(`nox), .ttol_c(`ttolcross), .vsup_min(`vsupmin), .enable_highz(`enable_highz), .duration(`duration), .ignore_xz(0), .vx(`vx), .vz(`vz), .ttol_t(`ttoltran), .tdeltran_rise(`tdeltran_rise), .tdeltran_fall(`tdeltran_fall), .ramp_type(`ramp_type), .rhi(`rhi), .rlo(`rlo), .rx(`rx), .rz(`rz), .analog_load(1), .r_SUPPLY(`rsupply), .r_PULL(`rpull), .r_LARGE(`rlarge), .r_WEAK(`rweak), .r_MEDIUM(`rmedium), .r_SMALL(`rsmall), .debug(`debug), .vinlimit(`vinlimit), .vddlimit(`vddlimit), .vpso(`vpso), .vsup_low_output_x(`vsup_low_output_x)  )ddiscrete_1_8, electrical;
connect uE2L  #(  .accuracy(`accuracy), .vsup(`vsup), .vhi(`vhi), .vlo(`vlo), .vthi(`vthi), .vtlo(`vtlo), .tr(`tr), .tf(`tf), .vtol(`vtol), .txdel(`txdel), .nox(`nox), .ttol_c(`ttolcross), .vsup_min(`vsupmin), .enable_highz(`enable_highz), .duration(`duration), .debug(`debug), .vinlimit(`vinlimit), .vddlimit(`vddlimit), .vpso(`vpso), .vsup_low_output_x(`vsup_low_output_x)  )ddiscrete_1_8, electrical;
connect uE2L_LPS  #(  .accuracy(`accuracy), .vsup(`vsup), .vhi(`vhi), .vlo(`vlo), .vthi(`vthi), .vtlo(`vtlo), .tr(`tr), .tf(`tf), .vtol(`vtol), .txdel(`txdel), .nox(`nox), .ttol_c(`ttolcross), .vsup_min(`vsupmin), .enable_highz(`enable_highz), .duration(`duration), .debug(`debug), .vinlimit(`vinlimit), .vddlimit(`vddlimit), .vpso(`vpso), .vsup_low_output_x(`vsup_low_output_x)  )ddiscrete_1_8, electrical;
connect uE2R  #(  .vdelta(`vdelta), .vtol(`vtoldelta), .ttol(`ttoldelta), .vss(`vss), .vsup(`vsup), .currentmode(`currentmode), .idelta(`idelta), .itol(`itoldelta), .vbias(`vbias), .rin(`rin), .debug(`debug), .vinlimit(`vinlimit)  )ddiscrete_1_8, electrical;
connect uERbidir  #(  .vdelta(`vdelta), .vtol(`vtoldelta), .ttol(`ttoldelta), .tr(`ttoldelta), .tf(`ttoldelta), .tdelay(`tdeltran), .ignore_xz(`ignore_xz), .rout(`rout), .rz(`rz), .vsup(`vsup), .currentmode(`currentmode), .idelta(`idelta), .itol(`itoldelta), .vbias(`vbias), .rin(`rin), .clamp(`clamp), .dvclamp(`dvclamp), .ix(`ix), .debug(`debug), .vinlimit(`vinlimit)  )ddiscrete_1_8, electrical;
connect uL2E  #(  .accuracy(`accuracy), .vsup(`vsup), .vhi(`vhi), .vlo(`vlo), .vthi(`vthi), .vtlo(`vtlo), .tr(`tr), .tf(`tf), .vtol(`vtol), .txdel(`txdel), .nox(`nox), .ttol_c(`ttolcross), .vsup_min(`vsupmin), .enable_highz(`enable_highz), .duration(`duration), .ignore_xz(`ignore_xz), .vx(`vx), .vz(`vz), .bidir_trangate(`bidir_trangate), .ttol_t(`ttoltran), .tdeltran_rise(`tdeltran_rise), .tdeltran_fall(`tdeltran_fall), .ramp_type(`ramp_type), .rhi(`rhi), .rlo(`rlo), .rx(`rx), .rz(`rz), .analog_load(`analog_load), .r_SUPPLY(`rsupply), .r_PULL(`rpull), .r_LARGE(`rlarge), .r_WEAK(`rweak), .r_MEDIUM(`rmedium), .r_SMALL(`rsmall), .debug(`debug), .vinlimit(`vinlimit), .vddlimit(`vddlimit), .vpso(`vpso), .vsup_low_output_x(`vsup_low_output_x), .enable_ilimit(`enable_ilimit), .ilimit(`ilimit)  )ddiscrete_1_8, electrical;
connect uL2E_LPS  #(  .accuracy(`accuracy), .vsup(`vsup), .vhi(`vhi), .vlo(`vlo), .vthi(`vthi), .vtlo(`vtlo), .tr(`tr), .tf(`tf), .vtol(`vtol), .txdel(`txdel), .nox(`nox), .ttol_c(`ttolcross), .vsup_min(`vsupmin), .enable_highz(`enable_highz), .duration(`duration), .ignore_xz(0), .vx(`vx), .vz(`vz), .ttol_t(`ttoltran), .tdeltran_rise(`tdeltran_rise), .tdeltran_fall(`tdeltran_fall), .ramp_type(`ramp_type), .rhi(`rhi), .rlo(`rlo), .rx(`rx), .rz(`rz), .analog_load(`analog_load), .r_SUPPLY(`rsupply), .r_PULL(`rpull), .r_LARGE(`rlarge), .r_WEAK(`rweak), .r_MEDIUM(`rmedium), .r_SMALL(`rsmall), .debug(`debug), .vinlimit(`vinlimit), .vddlimit(`vddlimit), .vpso(`vpso), .vsup_low_output_x(`vsup_low_output_x)  )ddiscrete_1_8, electrical;
connect uR2E  #(  .vsup(`vsup), .vdelta(`vdelta), .vss(`vss), .vx(`vx), .tr(`ttoldelta), .tf(`ttoldelta), .tdelay(`tdeltran), .ignore_xz(`ignore_xz), .rout(`rout), .rx(`rx), .rz(`rz), .currentmode(`currentmode), .idelta(`idelta), .clamp(`clamp), .dvclamp(`dvclamp), .ix(`ix), .debug(`debug), .vinlimit(`vinlimit)  )ddiscrete_1_8, electrical;
endconnectrules
